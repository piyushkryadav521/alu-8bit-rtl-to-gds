* NGSPICE file created from alu_8bit.ext - technology: sky130A

* Black-box entry subcircuit for sky130_fd_sc_hd__tapvpwrvgnd_1 abstract view
.subckt sky130_fd_sc_hd__tapvpwrvgnd_1 VGND VPWR
.ends

* Black-box entry subcircuit for sky130_fd_sc_hd__decap_4 abstract view
.subckt sky130_fd_sc_hd__decap_4 VGND VNB VPB VPWR
.ends

* Black-box entry subcircuit for sky130_fd_sc_hd__decap_3 abstract view
.subckt sky130_fd_sc_hd__decap_3 VGND VNB VPB VPWR
.ends

* Black-box entry subcircuit for sky130_ef_sc_hd__decap_12 abstract view
.subckt sky130_ef_sc_hd__decap_12 VPWR VGND VPB VNB
.ends

* Black-box entry subcircuit for sky130_fd_sc_hd__a31o_1 abstract view
.subckt sky130_fd_sc_hd__a31o_1 A1 A2 A3 B1 VGND VNB VPB VPWR X
.ends

* Black-box entry subcircuit for sky130_fd_sc_hd__o211a_1 abstract view
.subckt sky130_fd_sc_hd__o211a_1 A1 A2 B1 C1 VGND VNB VPB VPWR X
.ends

* Black-box entry subcircuit for sky130_fd_sc_hd__fill_2 abstract view
.subckt sky130_fd_sc_hd__fill_2 VGND VNB VPB VPWR
.ends

* Black-box entry subcircuit for sky130_fd_sc_hd__buf_2 abstract view
.subckt sky130_fd_sc_hd__buf_2 A VGND VNB VPB VPWR X
.ends

* Black-box entry subcircuit for sky130_fd_sc_hd__decap_8 abstract view
.subckt sky130_fd_sc_hd__decap_8 VGND VNB VPB VPWR
.ends

* Black-box entry subcircuit for sky130_fd_sc_hd__a21o_1 abstract view
.subckt sky130_fd_sc_hd__a21o_1 A1 A2 B1 VGND VNB VPB VPWR X
.ends

* Black-box entry subcircuit for sky130_fd_sc_hd__decap_6 abstract view
.subckt sky130_fd_sc_hd__decap_6 VGND VNB VPB VPWR
.ends

* Black-box entry subcircuit for sky130_fd_sc_hd__nand2_2 abstract view
.subckt sky130_fd_sc_hd__nand2_2 A B VGND VNB VPB VPWR Y
.ends

* Black-box entry subcircuit for sky130_fd_sc_hd__nand2_1 abstract view
.subckt sky130_fd_sc_hd__nand2_1 A B VGND VNB VPB VPWR Y
.ends

* Black-box entry subcircuit for sky130_fd_sc_hd__fill_1 abstract view
.subckt sky130_fd_sc_hd__fill_1 VGND VNB VPB VPWR
.ends

* Black-box entry subcircuit for sky130_fd_sc_hd__or2_1 abstract view
.subckt sky130_fd_sc_hd__or2_1 A B VGND VNB VPB VPWR X
.ends

* Black-box entry subcircuit for sky130_fd_sc_hd__o32a_1 abstract view
.subckt sky130_fd_sc_hd__o32a_1 A1 A2 A3 B1 B2 VGND VNB VPB VPWR X
.ends

* Black-box entry subcircuit for sky130_fd_sc_hd__and3_2 abstract view
.subckt sky130_fd_sc_hd__and3_2 A B C VGND VNB VPB VPWR X
.ends

* Black-box entry subcircuit for sky130_fd_sc_hd__and2_1 abstract view
.subckt sky130_fd_sc_hd__and2_1 A B VGND VNB VPB VPWR X
.ends

* Black-box entry subcircuit for sky130_fd_sc_hd__xor2_1 abstract view
.subckt sky130_fd_sc_hd__xor2_1 A B VGND VNB VPB VPWR X
.ends

* Black-box entry subcircuit for sky130_fd_sc_hd__o22ai_1 abstract view
.subckt sky130_fd_sc_hd__o22ai_1 A1 A2 B1 B2 VGND VNB VPB VPWR Y
.ends

* Black-box entry subcircuit for sky130_fd_sc_hd__a311o_1 abstract view
.subckt sky130_fd_sc_hd__a311o_1 A1 A2 A3 B1 C1 VGND VNB VPB VPWR X
.ends

* Black-box entry subcircuit for sky130_fd_sc_hd__nand3b_4 abstract view
.subckt sky130_fd_sc_hd__nand3b_4 A_N B C VGND VNB VPB VPWR Y
.ends

* Black-box entry subcircuit for sky130_fd_sc_hd__nor2_1 abstract view
.subckt sky130_fd_sc_hd__nor2_1 A B VGND VNB VPB VPWR Y
.ends

* Black-box entry subcircuit for sky130_fd_sc_hd__or3b_4 abstract view
.subckt sky130_fd_sc_hd__or3b_4 A B C_N VGND VNB VPB VPWR X
.ends

* Black-box entry subcircuit for sky130_fd_sc_hd__a2bb2o_1 abstract view
.subckt sky130_fd_sc_hd__a2bb2o_1 A1_N A2_N B1 B2 VGND VNB VPB VPWR X
.ends

* Black-box entry subcircuit for sky130_fd_sc_hd__or4_1 abstract view
.subckt sky130_fd_sc_hd__or4_1 A B C D VGND VNB VPB VPWR X
.ends

* Black-box entry subcircuit for sky130_fd_sc_hd__a21bo_1 abstract view
.subckt sky130_fd_sc_hd__a21bo_1 A1 A2 B1_N VGND VNB VPB VPWR X
.ends

* Black-box entry subcircuit for sky130_fd_sc_hd__a211o_1 abstract view
.subckt sky130_fd_sc_hd__a211o_1 A1 A2 B1 C1 VGND VNB VPB VPWR X
.ends

* Black-box entry subcircuit for sky130_fd_sc_hd__o22a_1 abstract view
.subckt sky130_fd_sc_hd__o22a_1 A1 A2 B1 B2 VGND VNB VPB VPWR X
.ends

* Black-box entry subcircuit for sky130_fd_sc_hd__o31a_1 abstract view
.subckt sky130_fd_sc_hd__o31a_1 A1 A2 A3 B1 VGND VNB VPB VPWR X
.ends

* Black-box entry subcircuit for sky130_fd_sc_hd__clkbuf_2 abstract view
.subckt sky130_fd_sc_hd__clkbuf_2 A VGND VNB VPB VPWR X
.ends

* Black-box entry subcircuit for sky130_fd_sc_hd__a221oi_1 abstract view
.subckt sky130_fd_sc_hd__a221oi_1 A1 A2 B1 B2 C1 VGND VNB VPB VPWR Y
.ends

* Black-box entry subcircuit for sky130_fd_sc_hd__o211ai_1 abstract view
.subckt sky130_fd_sc_hd__o211ai_1 A1 A2 B1 C1 VGND VNB VPB VPWR Y
.ends

* Black-box entry subcircuit for sky130_fd_sc_hd__nor3_1 abstract view
.subckt sky130_fd_sc_hd__nor3_1 A B C VGND VNB VPB VPWR Y
.ends

* Black-box entry subcircuit for sky130_fd_sc_hd__o21a_1 abstract view
.subckt sky130_fd_sc_hd__o21a_1 A1 A2 B1 VGND VNB VPB VPWR X
.ends

* Black-box entry subcircuit for sky130_fd_sc_hd__or3b_2 abstract view
.subckt sky130_fd_sc_hd__or3b_2 A B C_N VGND VNB VPB VPWR X
.ends

* Black-box entry subcircuit for sky130_fd_sc_hd__a22o_1 abstract view
.subckt sky130_fd_sc_hd__a22o_1 A1 A2 B1 B2 VGND VNB VPB VPWR X
.ends

* Black-box entry subcircuit for sky130_fd_sc_hd__nor3b_2 abstract view
.subckt sky130_fd_sc_hd__nor3b_2 A B C_N VGND VNB VPB VPWR Y
.ends

* Black-box entry subcircuit for sky130_fd_sc_hd__a221o_1 abstract view
.subckt sky130_fd_sc_hd__a221o_1 A1 A2 B1 B2 C1 VGND VNB VPB VPWR X
.ends

* Black-box entry subcircuit for sky130_fd_sc_hd__and3b_1 abstract view
.subckt sky130_fd_sc_hd__and3b_1 A_N B C VGND VNB VPB VPWR X
.ends

* Black-box entry subcircuit for sky130_fd_sc_hd__dlymetal6s2s_1 abstract view
.subckt sky130_fd_sc_hd__dlymetal6s2s_1 A VGND VNB VPB VPWR X
.ends

* Black-box entry subcircuit for sky130_fd_sc_hd__and3_1 abstract view
.subckt sky130_fd_sc_hd__and3_1 A B C VGND VNB VPB VPWR X
.ends

* Black-box entry subcircuit for sky130_fd_sc_hd__or3_1 abstract view
.subckt sky130_fd_sc_hd__or3_1 A B C VGND VNB VPB VPWR X
.ends

* Black-box entry subcircuit for sky130_fd_sc_hd__nand3_1 abstract view
.subckt sky130_fd_sc_hd__nand3_1 A B C VGND VNB VPB VPWR Y
.ends

* Black-box entry subcircuit for sky130_fd_sc_hd__nor2_2 abstract view
.subckt sky130_fd_sc_hd__nor2_2 A B VGND VNB VPB VPWR Y
.ends

* Black-box entry subcircuit for sky130_fd_sc_hd__o21ai_1 abstract view
.subckt sky130_fd_sc_hd__o21ai_1 A1 A2 B1 VGND VNB VPB VPWR Y
.ends

* Black-box entry subcircuit for sky130_fd_sc_hd__o2bb2a_1 abstract view
.subckt sky130_fd_sc_hd__o2bb2a_1 A1_N A2_N B1 B2 VGND VNB VPB VPWR X
.ends

* Black-box entry subcircuit for sky130_fd_sc_hd__and2b_1 abstract view
.subckt sky130_fd_sc_hd__and2b_1 A_N B VGND VNB VPB VPWR X
.ends

* Black-box entry subcircuit for sky130_fd_sc_hd__inv_2 abstract view
.subckt sky130_fd_sc_hd__inv_2 A VGND VNB VPB VPWR Y
.ends

* Black-box entry subcircuit for sky130_fd_sc_hd__o31ai_2 abstract view
.subckt sky130_fd_sc_hd__o31ai_2 A1 A2 A3 B1 VGND VNB VPB VPWR Y
.ends

* Black-box entry subcircuit for sky130_fd_sc_hd__nand2b_1 abstract view
.subckt sky130_fd_sc_hd__nand2b_1 A_N B VGND VNB VPB VPWR Y
.ends

* Black-box entry subcircuit for sky130_fd_sc_hd__buf_1 abstract view
.subckt sky130_fd_sc_hd__buf_1 A VGND VNB VPB VPWR X
.ends

* Black-box entry subcircuit for sky130_fd_sc_hd__clkbuf_1 abstract view
.subckt sky130_fd_sc_hd__clkbuf_1 A VGND VNB VPB VPWR X
.ends

* Black-box entry subcircuit for sky130_fd_sc_hd__or3_2 abstract view
.subckt sky130_fd_sc_hd__or3_2 A B C VGND VNB VPB VPWR X
.ends

* Black-box entry subcircuit for sky130_fd_sc_hd__nor3_4 abstract view
.subckt sky130_fd_sc_hd__nor3_4 A B C VGND VNB VPB VPWR Y
.ends

* Black-box entry subcircuit for sky130_fd_sc_hd__xnor2_1 abstract view
.subckt sky130_fd_sc_hd__xnor2_1 A B VGND VNB VPB VPWR Y
.ends

* Black-box entry subcircuit for sky130_fd_sc_hd__a32o_1 abstract view
.subckt sky130_fd_sc_hd__a32o_1 A1 A2 A3 B1 B2 VGND VNB VPB VPWR X
.ends

* Black-box entry subcircuit for sky130_fd_sc_hd__xnor2_2 abstract view
.subckt sky130_fd_sc_hd__xnor2_2 A B VGND VNB VPB VPWR Y
.ends

* Black-box entry subcircuit for sky130_fd_sc_hd__a21oi_1 abstract view
.subckt sky130_fd_sc_hd__a21oi_1 A1 A2 B1 VGND VNB VPB VPWR Y
.ends

* Black-box entry subcircuit for sky130_fd_sc_hd__nor4_1 abstract view
.subckt sky130_fd_sc_hd__nor4_1 A B C D VGND VNB VPB VPWR Y
.ends

* Black-box entry subcircuit for sky130_fd_sc_hd__o31ai_1 abstract view
.subckt sky130_fd_sc_hd__o31ai_1 A1 A2 A3 B1 VGND VNB VPB VPWR Y
.ends

.subckt alu_8bit A[0] A[1] A[2] A[3] A[4] A[5] A[6] A[7] B[0] B[1] B[2] B[3] B[4]
+ B[5] B[6] B[7] VGND VPWR carry opcode[0] opcode[1] opcode[2] result[0] result[1]
+ result[2] result[3] result[4] result[5] result[6] result[7] zero
XTAP_TAPCELL_ROW_12_54 VGND VPWR sky130_fd_sc_hd__tapvpwrvgnd_1
XFILLER_12_65 VGND VGND VPWR VPWR sky130_fd_sc_hd__decap_4
XFILLER_12_54 VGND VGND VPWR VPWR sky130_fd_sc_hd__decap_3
XFILLER_7_7 VPWR VGND VPWR VGND sky130_ef_sc_hd__decap_12
X_200_ _060_ _090_ _091_ _095_ VGND VGND VPWR VPWR _096_ sky130_fd_sc_hd__a31o_1
XPHY_EDGE_ROW_8_Left_25 VGND VGND VPWR VPWR sky130_fd_sc_hd__decap_3
X_131_ _073_ _024_ _030_ _076_ VGND VGND VPWR VPWR _033_ sky130_fd_sc_hd__o211a_1
XFILLER_0_57 VGND VGND VPWR VPWR sky130_fd_sc_hd__decap_3
XFILLER_13_3 VPWR VGND VPWR VGND sky130_ef_sc_hd__decap_12
XFILLER_6_56 VGND VGND VPWR VPWR sky130_fd_sc_hd__decap_4
XFILLER_15_54 VGND VGND VPWR VPWR sky130_fd_sc_hd__fill_2
XFILLER_13_101 VGND VGND VPWR VPWR sky130_fd_sc_hd__fill_2
Xoutput20 net20 VGND VGND VPWR VPWR carry sky130_fd_sc_hd__buf_2
XFILLER_3_57 VGND VGND VPWR VPWR sky130_fd_sc_hd__decap_8
XPHY_EDGE_ROW_12_Right_12 VGND VGND VPWR VPWR sky130_fd_sc_hd__decap_3
X_130_ _058_ _022_ _031_ VGND VGND VPWR VPWR _032_ sky130_fd_sc_hd__a21o_1
XFILLER_15_44 VGND VGND VPWR VPWR sky130_fd_sc_hd__decap_3
Xoutput21 net21 VGND VGND VPWR VPWR result[0] sky130_fd_sc_hd__buf_2
XPHY_EDGE_ROW_6_Right_6 VGND VGND VPWR VPWR sky130_fd_sc_hd__decap_3
XFILLER_6_68 VGND VGND VPWR VPWR sky130_fd_sc_hd__decap_6
XFILLER_3_25 VPWR VGND VPWR VGND sky130_ef_sc_hd__decap_12
X_189_ _083_ _084_ VGND VGND VPWR VPWR _085_ sky130_fd_sc_hd__nand2_2
XFILLER_0_15 VPWR VGND VPWR VGND sky130_ef_sc_hd__decap_12
XFILLER_3_3 VPWR VGND VPWR VGND sky130_ef_sc_hd__decap_12
XFILLER_6_25 VGND VGND VPWR VPWR sky130_fd_sc_hd__decap_3
Xoutput22 net22 VGND VGND VPWR VPWR result[1] sky130_fd_sc_hd__buf_2
XFILLER_12_46 VGND VGND VPWR VPWR sky130_fd_sc_hd__decap_8
XTAP_TAPCELL_ROW_8_47 VGND VPWR sky130_fd_sc_hd__tapvpwrvgnd_1
XFILLER_3_15 VGND VGND VPWR VPWR sky130_fd_sc_hd__fill_2
XFILLER_3_37 VGND VGND VPWR VPWR sky130_fd_sc_hd__decap_4
X_188_ net3 net11 VGND VGND VPWR VPWR _084_ sky130_fd_sc_hd__nand2_1
XFILLER_0_27 VGND VGND VPWR VPWR sky130_fd_sc_hd__fill_1
XFILLER_15_57 VGND VGND VPWR VPWR sky130_fd_sc_hd__fill_1
Xoutput23 net23 VGND VGND VPWR VPWR result[2] sky130_fd_sc_hd__buf_2
XFILLER_1_92 VGND VGND VPWR VPWR sky130_fd_sc_hd__decap_8
XTAP_TAPCELL_ROW_2_38 VGND VPWR sky130_fd_sc_hd__tapvpwrvgnd_1
X_187_ net3 net11 VGND VGND VPWR VPWR _083_ sky130_fd_sc_hd__or2_1
XFILLER_12_69 VGND VGND VPWR VPWR sky130_fd_sc_hd__fill_1
XTAP_TAPCELL_ROW_8_48 VGND VPWR sky130_fd_sc_hd__tapvpwrvgnd_1
XFILLER_4_81 VGND VGND VPWR VPWR sky130_fd_sc_hd__decap_3
XPHY_EDGE_ROW_12_Left_29 VGND VGND VPWR VPWR sky130_fd_sc_hd__decap_3
X_239_ _007_ _009_ VGND VGND VPWR VPWR _011_ sky130_fd_sc_hd__nand2_1
Xoutput24 net24 VGND VGND VPWR VPWR result[3] sky130_fd_sc_hd__buf_2
XTAP_TAPCELL_ROW_15_58 VGND VPWR sky130_fd_sc_hd__tapvpwrvgnd_1
XPHY_EDGE_ROW_15_Left_32 VGND VGND VPWR VPWR sky130_fd_sc_hd__decap_3
XFILLER_10_80 VGND VGND VPWR VPWR sky130_fd_sc_hd__decap_4
XTAP_TAPCELL_ROW_2_39 VGND VPWR sky130_fd_sc_hd__tapvpwrvgnd_1
XPHY_EDGE_ROW_0_Left_17 VGND VGND VPWR VPWR sky130_fd_sc_hd__decap_3
X_186_ _077_ _080_ _081_ _082_ _076_ VGND VGND VPWR VPWR net22 sky130_fd_sc_hd__o32a_1
XFILLER_4_93 VGND VGND VPWR VPWR sky130_fd_sc_hd__decap_3
XFILLER_1_3 VPWR VGND VPWR VGND sky130_ef_sc_hd__decap_12
XFILLER_0_29 VGND VGND VPWR VPWR sky130_fd_sc_hd__fill_2
XPHY_EDGE_ROW_3_Left_20 VGND VGND VPWR VPWR sky130_fd_sc_hd__decap_3
XFILLER_15_15 VPWR VGND VPWR VGND sky130_ef_sc_hd__decap_12
X_169_ net30 net31 net32 VGND VGND VPWR VPWR _067_ sky130_fd_sc_hd__and3_2
XFILLER_6_17 VGND VGND VPWR VPWR sky130_fd_sc_hd__fill_2
X_238_ _007_ _009_ VGND VGND VPWR VPWR _010_ sky130_fd_sc_hd__and2_1
Xoutput25 net25 VGND VGND VPWR VPWR result[4] sky130_fd_sc_hd__buf_2
XFILLER_13_81 VPWR VGND VPWR VGND sky130_ef_sc_hd__decap_12
XFILLER_12_27 VGND VGND VPWR VPWR sky130_fd_sc_hd__fill_1
X_185_ _059_ _069_ VGND VGND VPWR VPWR _082_ sky130_fd_sc_hd__xor2_1
XFILLER_5_102 VGND VGND VPWR VPWR sky130_fd_sc_hd__fill_1
X_168_ _059_ _064_ _065_ net1 VGND VGND VPWR VPWR _066_ sky130_fd_sc_hd__o22ai_1
X_237_ net6 net14 VGND VGND VPWR VPWR _009_ sky130_fd_sc_hd__or2_1
XFILLER_1_51 VGND VGND VPWR VPWR sky130_fd_sc_hd__decap_4
XFILLER_1_62 VGND VGND VPWR VPWR sky130_fd_sc_hd__fill_1
XFILLER_1_73 VGND VGND VPWR VPWR sky130_fd_sc_hd__decap_4
XFILLER_15_27 VGND VGND VPWR VPWR sky130_fd_sc_hd__fill_2
XFILLER_7_50 VGND VGND VPWR VPWR sky130_fd_sc_hd__decap_6
XFILLER_6_29 VGND VGND VPWR VPWR sky130_fd_sc_hd__decap_8
Xoutput26 net26 VGND VGND VPWR VPWR result[5] sky130_fd_sc_hd__buf_2
XPHY_EDGE_ROW_1_Right_1 VGND VGND VPWR VPWR sky130_fd_sc_hd__decap_3
XFILLER_7_83 VGND VGND VPWR VPWR sky130_fd_sc_hd__decap_4
XTAP_TAPCELL_ROW_3_40 VGND VPWR sky130_fd_sc_hd__tapvpwrvgnd_1
X_184_ _060_ _071_ _072_ _075_ _079_ VGND VGND VPWR VPWR _081_ sky130_fd_sc_hd__a311o_1
X_167_ net31 net32 net30 VGND VGND VPWR VPWR _065_ sky130_fd_sc_hd__nand3b_4
XTAP_TAPCELL_ROW_10_50 VGND VPWR sky130_fd_sc_hd__tapvpwrvgnd_1
X_219_ net5 net13 VGND VGND VPWR VPWR _113_ sky130_fd_sc_hd__nand2_2
X_236_ net6 net14 VGND VGND VPWR VPWR _008_ sky130_fd_sc_hd__nor2_1
XTAP_TAPCELL_ROW_16_60 VGND VPWR sky130_fd_sc_hd__tapvpwrvgnd_1
XPHY_EDGE_ROW_15_Right_15 VGND VGND VPWR VPWR sky130_fd_sc_hd__decap_3
Xoutput27 net27 VGND VGND VPWR VPWR result[6] sky130_fd_sc_hd__buf_2
XFILLER_12_29 VGND VGND VPWR VPWR sky130_fd_sc_hd__decap_6
XFILLER_4_85 VGND VGND VPWR VPWR sky130_fd_sc_hd__decap_8
X_166_ net30 net32 net31 VGND VGND VPWR VPWR _064_ sky130_fd_sc_hd__or3b_4
X_183_ _069_ _073_ _074_ net1 VGND VGND VPWR VPWR _080_ sky130_fd_sc_hd__a2bb2o_1
X_235_ net6 net14 VGND VGND VPWR VPWR _007_ sky130_fd_sc_hd__nand2_1
XTAP_TAPCELL_ROW_10_51 VGND VPWR sky130_fd_sc_hd__tapvpwrvgnd_1
XFILLER_10_40 VGND VGND VPWR VPWR sky130_fd_sc_hd__fill_2
X_218_ net5 net13 VGND VGND VPWR VPWR _112_ sky130_fd_sc_hd__or2_1
XPHY_EDGE_ROW_7_Left_24 VGND VGND VPWR VPWR sky130_fd_sc_hd__decap_3
X_149_ _075_ _047_ _048_ _049_ VGND VGND VPWR VPWR _050_ sky130_fd_sc_hd__or4_1
Xoutput28 net28 VGND VGND VPWR VPWR result[7] sky130_fd_sc_hd__buf_2
XTAP_TAPCELL_ROW_16_61 VGND VPWR sky130_fd_sc_hd__tapvpwrvgnd_1
Xfanout30 net19 VGND VGND VPWR VPWR net30 sky130_fd_sc_hd__buf_2
XFILLER_13_62 VGND VGND VPWR VPWR sky130_fd_sc_hd__decap_6
X_182_ net3 _067_ _078_ VGND VGND VPWR VPWR _079_ sky130_fd_sc_hd__a21bo_1
X_251_ net7 net15 VGND VGND VPWR VPWR _022_ sky130_fd_sc_hd__or2_1
X_217_ _075_ _103_ _107_ _111_ VGND VGND VPWR VPWR net24 sky130_fd_sc_hd__a211o_1
X_165_ net1 net9 _058_ _062_ VGND VGND VPWR VPWR _063_ sky130_fd_sc_hd__o22a_1
X_148_ net8 _065_ _074_ net7 VGND VGND VPWR VPWR _049_ sky130_fd_sc_hd__a2bb2o_1
X_234_ _002_ _004_ _006_ _118_ VGND VGND VPWR VPWR net25 sky130_fd_sc_hd__o31a_1
XFILLER_7_75 VGND VGND VPWR VPWR sky130_fd_sc_hd__decap_4
XFILLER_7_31 VPWR VGND VPWR VGND sky130_ef_sc_hd__decap_12
XPHY_EDGE_ROW_5_Right_5 VGND VGND VPWR VPWR sky130_fd_sc_hd__decap_3
Xoutput29 net29 VGND VGND VPWR VPWR zero sky130_fd_sc_hd__buf_2
XFILLER_4_10 VGND VGND VPWR VPWR sky130_fd_sc_hd__fill_1
Xfanout31 net18 VGND VGND VPWR VPWR net31 sky130_fd_sc_hd__clkbuf_2
X_164_ net1 net9 net30 net32 net31 VGND VGND VPWR VPWR _062_ sky130_fd_sc_hd__a221oi_1
X_181_ net2 _065_ _068_ _064_ VGND VGND VPWR VPWR _078_ sky130_fd_sc_hd__o22a_1
X_233_ net4 _074_ _075_ _005_ VGND VGND VPWR VPWR _006_ sky130_fd_sc_hd__a211o_1
XFILLER_1_55 VGND VGND VPWR VPWR sky130_fd_sc_hd__fill_1
XFILLER_1_77 VGND VGND VPWR VPWR sky130_fd_sc_hd__fill_1
X_250_ _012_ _013_ _017_ _021_ VGND VGND VPWR VPWR net26 sky130_fd_sc_hd__o211ai_1
X_216_ _108_ _109_ _110_ VGND VGND VPWR VPWR _111_ sky130_fd_sc_hd__nor3_1
X_147_ _073_ _040_ _038_ _058_ VGND VGND VPWR VPWR _048_ sky130_fd_sc_hd__a2bb2o_1
XFILLER_16_85 VPWR VGND VPWR VGND sky130_ef_sc_hd__decap_12
XFILLER_16_63 VGND VGND VPWR VPWR sky130_fd_sc_hd__decap_3
XPHY_EDGE_ROW_11_Right_11 VGND VGND VPWR VPWR sky130_fd_sc_hd__decap_3
XFILLER_7_98 VGND VGND VPWR VPWR sky130_fd_sc_hd__fill_1
XFILLER_7_43 VGND VGND VPWR VPWR sky130_fd_sc_hd__fill_2
Xfanout32 net17 VGND VGND VPWR VPWR net32 sky130_fd_sc_hd__buf_2
XFILLER_13_53 VGND VGND VPWR VPWR sky130_fd_sc_hd__decap_3
X_180_ net2 net10 _058_ VGND VGND VPWR VPWR _077_ sky130_fd_sc_hd__o21a_1
XTAP_TAPCELL_ROW_0_34 VGND VPWR sky130_fd_sc_hd__tapvpwrvgnd_1
X_163_ net30 net31 net32 VGND VGND VPWR VPWR _061_ sky130_fd_sc_hd__or3b_2
X_232_ _064_ _113_ _114_ _073_ VGND VGND VPWR VPWR _005_ sky130_fd_sc_hd__o22ai_1
X_215_ _085_ _089_ _101_ _061_ VGND VGND VPWR VPWR _110_ sky130_fd_sc_hd__a31o_1
X_146_ _064_ _039_ VGND VGND VPWR VPWR _047_ sky130_fd_sc_hd__nor2_1
XTAP_TAPCELL_ROW_6_44 VGND VPWR sky130_fd_sc_hd__tapvpwrvgnd_1
X_129_ net8 _067_ _074_ net6 VGND VGND VPWR VPWR _031_ sky130_fd_sc_hd__a22o_1
XFILLER_16_97 VGND VGND VPWR VPWR sky130_fd_sc_hd__decap_6
XFILLER_4_34 VGND VGND VPWR VPWR sky130_fd_sc_hd__decap_6
XFILLER_13_21 VGND VGND VPWR VPWR sky130_fd_sc_hd__decap_6
X_162_ net30 net31 net32 VGND VGND VPWR VPWR _060_ sky130_fd_sc_hd__nor3b_2
X_231_ net6 _067_ _112_ _058_ _003_ VGND VGND VPWR VPWR _004_ sky130_fd_sc_hd__a221o_1
XTAP_TAPCELL_ROW_0_35 VGND VPWR sky130_fd_sc_hd__tapvpwrvgnd_1
XFILLER_1_100 VGND VGND VPWR VPWR sky130_fd_sc_hd__decap_3
X_214_ net11 _101_ net3 VGND VGND VPWR VPWR _109_ sky130_fd_sc_hd__and3b_1
XPHY_EDGE_ROW_11_Left_28 VGND VGND VPWR VPWR sky130_fd_sc_hd__decap_3
XFILLER_10_33 VGND VGND VPWR VPWR sky130_fd_sc_hd__fill_1
XFILLER_10_22 VGND VGND VPWR VPWR sky130_fd_sc_hd__decap_6
Xinput1 A[0] VGND VGND VPWR VPWR net1 sky130_fd_sc_hd__dlymetal6s2s_1
XTAP_TAPCELL_ROW_6_45 VGND VPWR sky130_fd_sc_hd__tapvpwrvgnd_1
X_145_ _060_ _044_ _045_ VGND VGND VPWR VPWR _046_ sky130_fd_sc_hd__and3_1
XFILLER_16_76 VGND VGND VPWR VPWR sky130_fd_sc_hd__decap_8
XPHY_EDGE_ROW_9_Right_9 VGND VGND VPWR VPWR sky130_fd_sc_hd__decap_3
X_128_ net7 _065_ _023_ _064_ VGND VGND VPWR VPWR _030_ sky130_fd_sc_hd__o22a_1
XFILLER_13_77 VGND VGND VPWR VPWR sky130_fd_sc_hd__fill_1
XTAP_TAPCELL_ROW_13_55 VGND VPWR sky130_fd_sc_hd__tapvpwrvgnd_1
XPHY_EDGE_ROW_14_Left_31 VGND VGND VPWR VPWR sky130_fd_sc_hd__decap_3
XTAP_TAPCELL_ROW_0_36 VGND VPWR sky130_fd_sc_hd__tapvpwrvgnd_1
X_161_ net1 net9 VGND VGND VPWR VPWR _059_ sky130_fd_sc_hd__nand2_1
X_230_ net5 _065_ VGND VGND VPWR VPWR _003_ sky130_fd_sc_hd__nor2_1
Xinput2 A[1] VGND VGND VPWR VPWR net2 sky130_fd_sc_hd__clkbuf_2
XFILLER_16_3 VPWR VGND VPWR VGND sky130_ef_sc_hd__decap_12
XFILLER_15_100 VGND VGND VPWR VPWR sky130_fd_sc_hd__decap_3
X_213_ _055_ net11 _090_ _100_ VGND VGND VPWR VPWR _108_ sky130_fd_sc_hd__o211a_1
XFILLER_7_79 VGND VGND VPWR VPWR sky130_fd_sc_hd__fill_1
XFILLER_7_57 VGND VGND VPWR VPWR sky130_fd_sc_hd__decap_3
X_127_ _024_ _027_ VGND VGND VPWR VPWR _029_ sky130_fd_sc_hd__and2_1
X_144_ _029_ _040_ _043_ VGND VGND VPWR VPWR _045_ sky130_fd_sc_hd__or3_1
XFILLER_4_47 VPWR VGND VPWR VGND sky130_ef_sc_hd__decap_12
XFILLER_13_45 VGND VGND VPWR VPWR sky130_fd_sc_hd__decap_8
Xinput3 A[2] VGND VGND VPWR VPWR net3 sky130_fd_sc_hd__clkbuf_2
X_212_ _104_ _105_ _106_ VGND VGND VPWR VPWR _107_ sky130_fd_sc_hd__nand3_1
X_160_ net30 _057_ VGND VGND VPWR VPWR _058_ sky130_fd_sc_hd__nor2_2
XFILLER_10_57 VPWR VGND VPWR VGND sky130_ef_sc_hd__decap_12
XFILLER_1_15 VGND VGND VPWR VPWR sky130_fd_sc_hd__decap_8
X_143_ _029_ _043_ _040_ VGND VGND VPWR VPWR _044_ sky130_fd_sc_hd__o21ai_1
XPHY_EDGE_ROW_0_Right_0 VGND VGND VPWR VPWR sky130_fd_sc_hd__decap_3
X_126_ _024_ _027_ VGND VGND VPWR VPWR _028_ sky130_fd_sc_hd__nor2_1
XFILLER_13_68 VGND VGND VPWR VPWR sky130_fd_sc_hd__fill_1
XFILLER_13_57 VGND VGND VPWR VPWR sky130_fd_sc_hd__fill_1
XFILLER_4_59 VGND VGND VPWR VPWR sky130_fd_sc_hd__decap_8
Xinput4 A[3] VGND VGND VPWR VPWR net4 sky130_fd_sc_hd__buf_2
XFILLER_10_69 VGND VGND VPWR VPWR sky130_fd_sc_hd__decap_4
X_211_ net5 _067_ _065_ net4 VGND VGND VPWR VPWR _106_ sky130_fd_sc_hd__o2bb2a_1
X_142_ net15 net7 VGND VGND VPWR VPWR _043_ sky130_fd_sc_hd__and2b_1
X_125_ _114_ _120_ _011_ _020_ _026_ VGND VGND VPWR VPWR _027_ sky130_fd_sc_hd__a311o_1
XFILLER_16_57 VGND VGND VPWR VPWR sky130_fd_sc_hd__fill_2
XFILLER_4_27 VGND VGND VPWR VPWR sky130_fd_sc_hd__fill_1
X_210_ net3 _074_ _098_ _064_ VGND VGND VPWR VPWR _105_ sky130_fd_sc_hd__o2bb2a_1
Xinput5 A[4] VGND VGND VPWR VPWR net5 sky130_fd_sc_hd__clkbuf_2
XFILLER_1_39 VGND VGND VPWR VPWR sky130_fd_sc_hd__decap_3
X_141_ _040_ _041_ VGND VGND VPWR VPWR _042_ sky130_fd_sc_hd__xor2_1
XPHY_EDGE_ROW_6_Left_23 VGND VGND VPWR VPWR sky130_fd_sc_hd__decap_3
X_124_ _025_ VGND VGND VPWR VPWR _026_ sky130_fd_sc_hd__inv_2
XFILLER_2_82 VGND VGND VPWR VPWR sky130_fd_sc_hd__fill_2
XFILLER_14_3 VPWR VGND VPWR VGND sky130_ef_sc_hd__decap_12
XFILLER_13_15 VGND VGND VPWR VPWR sky130_fd_sc_hd__decap_3
XTAP_TAPCELL_ROW_9_49 VGND VPWR sky130_fd_sc_hd__tapvpwrvgnd_1
XFILLER_5_82 VGND VGND VPWR VPWR sky130_fd_sc_hd__fill_1
XPHY_EDGE_ROW_14_Right_14 VGND VGND VPWR VPWR sky130_fd_sc_hd__decap_3
Xinput6 A[5] VGND VGND VPWR VPWR net6 sky130_fd_sc_hd__clkbuf_2
X_140_ _008_ _024_ _035_ _023_ VGND VGND VPWR VPWR _041_ sky130_fd_sc_hd__o31ai_2
XFILLER_16_37 VGND VGND VPWR VPWR sky130_fd_sc_hd__decap_8
XTAP_TAPCELL_ROW_16_59 VGND VPWR sky130_fd_sc_hd__tapvpwrvgnd_1
XFILLER_16_15 VPWR VGND VPWR VGND sky130_ef_sc_hd__decap_12
XPHY_EDGE_ROW_4_Right_4 VGND VGND VPWR VPWR sky130_fd_sc_hd__decap_3
X_123_ net14 net6 VGND VGND VPWR VPWR _025_ sky130_fd_sc_hd__nand2b_1
XFILLER_13_27 VGND VGND VPWR VPWR sky130_fd_sc_hd__fill_1
XFILLER_14_81 VGND VGND VPWR VPWR sky130_fd_sc_hd__decap_3
Xinput7 A[6] VGND VGND VPWR VPWR net7 sky130_fd_sc_hd__buf_1
XFILLER_16_49 VGND VGND VPWR VPWR sky130_fd_sc_hd__decap_3
XFILLER_16_27 VGND VGND VPWR VPWR sky130_fd_sc_hd__fill_1
X_199_ _058_ _083_ _092_ _075_ VGND VGND VPWR VPWR _095_ sky130_fd_sc_hd__a211o_1
Xinput10 B[1] VGND VGND VPWR VPWR net10 sky130_fd_sc_hd__dlymetal6s2s_1
X_122_ _022_ _023_ VGND VGND VPWR VPWR _024_ sky130_fd_sc_hd__nand2_2
X_198_ _064_ _084_ _093_ VGND VGND VPWR VPWR _094_ sky130_fd_sc_hd__o21ai_1
XFILLER_10_29 VGND VGND VPWR VPWR sky130_fd_sc_hd__decap_4
Xinput8 A[7] VGND VGND VPWR VPWR net8 sky130_fd_sc_hd__clkbuf_1
XFILLER_2_63 VGND VGND VPWR VPWR sky130_fd_sc_hd__fill_1
XFILLER_2_85 VGND VGND VPWR VPWR sky130_fd_sc_hd__fill_2
Xinput11 B[2] VGND VGND VPWR VPWR net11 sky130_fd_sc_hd__buf_1
XFILLER_7_19 VPWR VGND VPWR VGND sky130_ef_sc_hd__decap_12
X_121_ net7 net15 VGND VGND VPWR VPWR _023_ sky130_fd_sc_hd__nand2_1
XFILLER_12_3 VGND VGND VPWR VPWR sky130_fd_sc_hd__decap_3
XTAP_TAPCELL_ROW_4_41 VGND VPWR sky130_fd_sc_hd__tapvpwrvgnd_1
Xinput9 B[0] VGND VGND VPWR VPWR net9 sky130_fd_sc_hd__clkbuf_1
XFILLER_5_74 VGND VGND VPWR VPWR sky130_fd_sc_hd__decap_8
Xinput12 B[3] VGND VGND VPWR VPWR net12 sky130_fd_sc_hd__dlymetal6s2s_1
X_197_ net3 _065_ _073_ _085_ VGND VGND VPWR VPWR _093_ sky130_fd_sc_hd__o22a_1
XFILLER_11_40 VGND VGND VPWR VPWR sky130_fd_sc_hd__fill_2
XPHY_EDGE_ROW_10_Right_10 VGND VGND VPWR VPWR sky130_fd_sc_hd__decap_3
XPHY_EDGE_ROW_10_Left_27 VGND VGND VPWR VPWR sky130_fd_sc_hd__decap_3
X_249_ _061_ _018_ _019_ _020_ VGND VGND VPWR VPWR _021_ sky130_fd_sc_hd__or4_1
XFILLER_16_29 VGND VGND VPWR VPWR sky130_fd_sc_hd__fill_2
XFILLER_8_85 VPWR VGND VPWR VGND sky130_ef_sc_hd__decap_12
XTAP_TAPCELL_ROW_4_42 VGND VPWR sky130_fd_sc_hd__tapvpwrvgnd_1
XPHY_EDGE_ROW_13_Left_30 VGND VGND VPWR VPWR sky130_fd_sc_hd__decap_3
XPHY_EDGE_ROW_8_Right_8 VGND VGND VPWR VPWR sky130_fd_sc_hd__decap_3
XFILLER_5_53 VGND VGND VPWR VPWR sky130_fd_sc_hd__decap_3
XFILLER_14_73 VGND VGND VPWR VPWR sky130_fd_sc_hd__decap_8
X_196_ net4 _067_ _074_ net2 VGND VGND VPWR VPWR _092_ sky130_fd_sc_hd__a22o_1
XFILLER_4_6 VGND VGND VPWR VPWR sky130_fd_sc_hd__decap_4
X_179_ net30 net31 net32 VGND VGND VPWR VPWR _076_ sky130_fd_sc_hd__or3_2
XTAP_TAPCELL_ROW_11_52 VGND VPWR sky130_fd_sc_hd__tapvpwrvgnd_1
Xinput13 B[4] VGND VGND VPWR VPWR net13 sky130_fd_sc_hd__buf_1
X_248_ net13 _011_ net5 VGND VGND VPWR VPWR _020_ sky130_fd_sc_hd__and3b_1
XFILLER_2_3 VPWR VGND VPWR VGND sky130_ef_sc_hd__decap_12
XFILLER_8_64 VPWR VGND VPWR VGND sky130_ef_sc_hd__decap_12
XFILLER_14_85 VGND VGND VPWR VPWR sky130_fd_sc_hd__decap_8
XFILLER_5_65 VGND VGND VPWR VPWR sky130_fd_sc_hd__fill_2
XFILLER_11_20 VPWR VGND VPWR VGND sky130_ef_sc_hd__decap_12
X_195_ _085_ _089_ VGND VGND VPWR VPWR _091_ sky130_fd_sc_hd__or2_1
X_247_ _000_ _010_ VGND VGND VPWR VPWR _019_ sky130_fd_sc_hd__nor2_1
Xinput14 B[5] VGND VGND VPWR VPWR net14 sky130_fd_sc_hd__buf_1
XFILLER_2_99 VGND VGND VPWR VPWR sky130_fd_sc_hd__fill_1
X_178_ net19 net18 net17 VGND VGND VPWR VPWR _075_ sky130_fd_sc_hd__nor3_4
XFILLER_8_76 VGND VGND VPWR VPWR sky130_fd_sc_hd__decap_8
XFILLER_8_43 VPWR VGND VPWR VGND sky130_ef_sc_hd__decap_12
XFILLER_10_3 VGND VGND VPWR VPWR sky130_fd_sc_hd__decap_3
X_194_ _085_ _089_ VGND VGND VPWR VPWR _090_ sky130_fd_sc_hd__nand2_1
X_177_ net32 net31 net30 VGND VGND VPWR VPWR _074_ sky130_fd_sc_hd__and3b_1
XFILLER_11_102 VGND VGND VPWR VPWR sky130_fd_sc_hd__fill_1
XFILLER_11_65 VGND VGND VPWR VPWR sky130_fd_sc_hd__fill_2
XFILLER_11_32 VGND VGND VPWR VPWR sky130_fd_sc_hd__decap_8
X_246_ _056_ net13 _000_ _010_ VGND VGND VPWR VPWR _018_ sky130_fd_sc_hd__o211a_1
Xinput15 B[6] VGND VGND VPWR VPWR net15 sky130_fd_sc_hd__clkbuf_1
XFILLER_8_55 VGND VGND VPWR VPWR sky130_fd_sc_hd__decap_4
X_229_ _000_ _001_ VGND VGND VPWR VPWR _002_ sky130_fd_sc_hd__and2_1
XFILLER_5_45 VGND VGND VPWR VPWR sky130_fd_sc_hd__fill_1
XFILLER_11_55 VGND VGND VPWR VPWR sky130_fd_sc_hd__fill_1
XFILLER_11_11 VGND VGND VPWR VPWR sky130_fd_sc_hd__decap_4
X_193_ _069_ _070_ _088_ VGND VGND VPWR VPWR _089_ sky130_fd_sc_hd__a21o_1
XPHY_EDGE_ROW_2_Left_19 VGND VGND VPWR VPWR sky130_fd_sc_hd__decap_3
XFILLER_2_57 VGND VGND VPWR VPWR sky130_fd_sc_hd__decap_3
X_159_ net31 net32 VGND VGND VPWR VPWR _057_ sky130_fd_sc_hd__nand2_1
X_176_ net31 net32 net19 VGND VGND VPWR VPWR _073_ sky130_fd_sc_hd__or3b_2
Xinput16 B[7] VGND VGND VPWR VPWR net16 sky130_fd_sc_hd__clkbuf_1
XFILLER_8_23 VGND VGND VPWR VPWR sky130_fd_sc_hd__decap_4
X_228_ _114_ _120_ _060_ VGND VGND VPWR VPWR _001_ sky130_fd_sc_hd__o21a_1
X_245_ _014_ _015_ _016_ VGND VGND VPWR VPWR _017_ sky130_fd_sc_hd__and3_1
XPHY_EDGE_ROW_5_Left_22 VGND VGND VPWR VPWR sky130_fd_sc_hd__decap_3
XFILLER_0_3 VPWR VGND VPWR VGND sky130_ef_sc_hd__decap_12
XFILLER_5_57 VGND VGND VPWR VPWR sky130_fd_sc_hd__decap_8
XFILLER_0_90 VPWR VGND VPWR VGND sky130_ef_sc_hd__decap_12
XFILLER_0_102 VGND VGND VPWR VPWR sky130_fd_sc_hd__fill_1
X_192_ net10 net2 VGND VGND VPWR VPWR _088_ sky130_fd_sc_hd__and2b_1
Xinput17 opcode[0] VGND VGND VPWR VPWR net17 sky130_fd_sc_hd__buf_1
X_175_ _069_ _070_ VGND VGND VPWR VPWR _072_ sky130_fd_sc_hd__or2_1
X_244_ net7 _067_ _065_ net6 VGND VGND VPWR VPWR _016_ sky130_fd_sc_hd__o2bb2a_1
XTAP_TAPCELL_ROW_7_46 VGND VPWR sky130_fd_sc_hd__tapvpwrvgnd_1
X_227_ _114_ _120_ VGND VGND VPWR VPWR _000_ sky130_fd_sc_hd__nand2_1
X_158_ net5 VGND VGND VPWR VPWR _056_ sky130_fd_sc_hd__inv_2
XTAP_TAPCELL_ROW_14_56 VGND VPWR sky130_fd_sc_hd__tapvpwrvgnd_1
XTAP_TAPCELL_ROW_1_37 VGND VPWR sky130_fd_sc_hd__tapvpwrvgnd_1
XPHY_EDGE_ROW_3_Right_3 VGND VGND VPWR VPWR sky130_fd_sc_hd__decap_3
X_191_ _085_ _086_ VGND VGND VPWR VPWR _087_ sky130_fd_sc_hd__xnor2_1
XFILLER_11_57 VGND VGND VPWR VPWR sky130_fd_sc_hd__decap_8
XFILLER_2_15 VGND VGND VPWR VPWR sky130_fd_sc_hd__decap_6
X_157_ net3 VGND VGND VPWR VPWR _055_ sky130_fd_sc_hd__inv_2
Xinput18 opcode[1] VGND VGND VPWR VPWR net18 sky130_fd_sc_hd__buf_1
X_226_ _085_ _089_ _101_ _109_ _119_ VGND VGND VPWR VPWR _120_ sky130_fd_sc_hd__a311o_1
X_174_ _069_ _070_ VGND VGND VPWR VPWR _071_ sky130_fd_sc_hd__nand2_1
X_243_ net5 _074_ _007_ _064_ VGND VGND VPWR VPWR _015_ sky130_fd_sc_hd__o2bb2a_1
X_209_ net30 _057_ _099_ _101_ _073_ VGND VGND VPWR VPWR _104_ sky130_fd_sc_hd__o32a_1
XPHY_EDGE_ROW_13_Right_13 VGND VGND VPWR VPWR sky130_fd_sc_hd__decap_3
XTAP_TAPCELL_ROW_14_57 VGND VPWR sky130_fd_sc_hd__tapvpwrvgnd_1
Xinput19 opcode[2] VGND VGND VPWR VPWR net19 sky130_fd_sc_hd__buf_1
X_173_ net1 net9 VGND VGND VPWR VPWR _070_ sky130_fd_sc_hd__nand2b_1
X_190_ _059_ _069_ _068_ VGND VGND VPWR VPWR _086_ sky130_fd_sc_hd__o21ai_1
X_242_ _058_ _009_ _011_ _073_ VGND VGND VPWR VPWR _014_ sky130_fd_sc_hd__o2bb2a_1
XFILLER_2_27 VGND VGND VPWR VPWR sky130_fd_sc_hd__fill_1
X_225_ net12 net4 VGND VGND VPWR VPWR _119_ sky130_fd_sc_hd__and2b_1
XPHY_EDGE_ROW_9_Left_26 VGND VGND VPWR VPWR sky130_fd_sc_hd__decap_3
X_156_ _060_ _044_ _053_ _054_ _075_ VGND VGND VPWR VPWR net20 sky130_fd_sc_hd__a32o_1
XFILLER_3_102 VGND VGND VPWR VPWR sky130_fd_sc_hd__fill_1
X_208_ _101_ _102_ VGND VGND VPWR VPWR _103_ sky130_fd_sc_hd__xnor2_1
XFILLER_14_47 VGND VGND VPWR VPWR sky130_fd_sc_hd__fill_1
XFILLER_9_80 VGND VGND VPWR VPWR sky130_fd_sc_hd__decap_6
X_139_ _038_ _039_ VGND VGND VPWR VPWR _040_ sky130_fd_sc_hd__nand2_1
XFILLER_0_71 VPWR VGND VPWR VGND sky130_ef_sc_hd__decap_12
XFILLER_8_27 VGND VGND VPWR VPWR sky130_fd_sc_hd__fill_1
X_172_ net2 net10 VGND VGND VPWR VPWR _069_ sky130_fd_sc_hd__xnor2_2
X_155_ _038_ _041_ _039_ VGND VGND VPWR VPWR _054_ sky130_fd_sc_hd__a21bo_1
X_241_ _113_ _116_ _011_ _076_ VGND VGND VPWR VPWR _013_ sky130_fd_sc_hd__a31o_1
X_224_ _116_ _117_ _076_ VGND VGND VPWR VPWR _118_ sky130_fd_sc_hd__a21o_1
X_207_ _083_ _086_ _084_ VGND VGND VPWR VPWR _102_ sky130_fd_sc_hd__a21bo_1
X_138_ net8 net16 VGND VGND VPWR VPWR _039_ sky130_fd_sc_hd__nand2_1
XFILLER_0_83 VGND VGND VPWR VPWR sky130_fd_sc_hd__fill_1
XFILLER_14_59 VGND VGND VPWR VPWR sky130_fd_sc_hd__decap_3
XFILLER_14_15 VGND VGND VPWR VPWR sky130_fd_sc_hd__decap_8
XPHY_EDGE_ROW_7_Right_7 VGND VGND VPWR VPWR sky130_fd_sc_hd__decap_3
XFILLER_6_82 VGND VGND VPWR VPWR sky130_fd_sc_hd__fill_2
XFILLER_5_28 VGND VGND VPWR VPWR sky130_fd_sc_hd__decap_4
XFILLER_15_80 VPWR VGND VPWR VGND sky130_ef_sc_hd__decap_12
XFILLER_11_49 VGND VGND VPWR VPWR sky130_fd_sc_hd__decap_6
X_171_ net2 net10 VGND VGND VPWR VPWR _068_ sky130_fd_sc_hd__nand2_1
X_240_ _113_ _116_ _011_ VGND VGND VPWR VPWR _012_ sky130_fd_sc_hd__a21oi_1
XFILLER_2_29 VGND VGND VPWR VPWR sky130_fd_sc_hd__fill_2
X_154_ net16 net8 VGND VGND VPWR VPWR _053_ sky130_fd_sc_hd__nand2b_1
XFILLER_6_101 VGND VGND VPWR VPWR sky130_fd_sc_hd__fill_2
XFILLER_3_50 VGND VGND VPWR VPWR sky130_fd_sc_hd__decap_6
X_223_ _114_ _115_ VGND VGND VPWR VPWR _117_ sky130_fd_sc_hd__nand2_1
XFILLER_3_83 VGND VGND VPWR VPWR sky130_fd_sc_hd__fill_2
X_206_ net4 net12 VGND VGND VPWR VPWR _101_ sky130_fd_sc_hd__xnor2_2
X_137_ net8 net16 VGND VGND VPWR VPWR _038_ sky130_fd_sc_hd__or2_1
XFILLER_15_92 VGND VGND VPWR VPWR sky130_fd_sc_hd__decap_8
X_170_ net2 _067_ _066_ _063_ VGND VGND VPWR VPWR net21 sky130_fd_sc_hd__a211o_1
X_205_ _097_ _099_ VGND VGND VPWR VPWR _100_ sky130_fd_sc_hd__nor2_1
XFILLER_9_72 VGND VGND VPWR VPWR sky130_fd_sc_hd__fill_2
X_222_ _114_ _115_ VGND VGND VPWR VPWR _116_ sky130_fd_sc_hd__or2_1
X_153_ net26 net27 net28 _052_ VGND VGND VPWR VPWR net29 sky130_fd_sc_hd__nor4_1
XFILLER_0_85 VGND VGND VPWR VPWR sky130_fd_sc_hd__fill_2
X_136_ _075_ _037_ _034_ _032_ VGND VGND VPWR VPWR net27 sky130_fd_sc_hd__o2bb2a_1
X_221_ _100_ _102_ _097_ VGND VGND VPWR VPWR _115_ sky130_fd_sc_hd__a21oi_1
XFILLER_12_83 VGND VGND VPWR VPWR sky130_fd_sc_hd__fill_1
X_152_ net25 _051_ VGND VGND VPWR VPWR _052_ sky130_fd_sc_hd__or2_1
X_204_ net4 net12 VGND VGND VPWR VPWR _099_ sky130_fd_sc_hd__nor2_1
XFILLER_0_42 VGND VGND VPWR VPWR sky130_fd_sc_hd__fill_2
X_135_ _024_ _036_ VGND VGND VPWR VPWR _037_ sky130_fd_sc_hd__xor2_1
XPHY_EDGE_ROW_16_Left_33 VGND VGND VPWR VPWR sky130_fd_sc_hd__decap_3
XPHY_EDGE_ROW_1_Left_18 VGND VGND VPWR VPWR sky130_fd_sc_hd__decap_3
XFILLER_3_75 VGND VGND VPWR VPWR sky130_fd_sc_hd__decap_8
X_203_ net4 net12 VGND VGND VPWR VPWR _098_ sky130_fd_sc_hd__nand2_1
X_151_ net21 net22 net23 net24 VGND VGND VPWR VPWR _051_ sky130_fd_sc_hd__or4_1
X_220_ _112_ _113_ VGND VGND VPWR VPWR _114_ sky130_fd_sc_hd__nand2_2
XPHY_EDGE_ROW_4_Left_21 VGND VGND VPWR VPWR sky130_fd_sc_hd__decap_3
X_134_ _008_ _035_ VGND VGND VPWR VPWR _036_ sky130_fd_sc_hd__nor2_1
XFILLER_15_3 VPWR VGND VPWR VGND sky130_ef_sc_hd__decap_12
XPHY_EDGE_ROW_16_Right_16 VGND VGND VPWR VPWR sky130_fd_sc_hd__decap_3
XFILLER_3_65 VGND VGND VPWR VPWR sky130_fd_sc_hd__fill_1
X_150_ _075_ _042_ _046_ _050_ VGND VGND VPWR VPWR net28 sky130_fd_sc_hd__o2bb2a_1
X_202_ net4 net12 VGND VGND VPWR VPWR _097_ sky130_fd_sc_hd__and2_1
XFILLER_9_53 VGND VGND VPWR VPWR sky130_fd_sc_hd__decap_3
XFILLER_9_20 VGND VGND VPWR VPWR sky130_fd_sc_hd__fill_2
X_133_ _114_ _115_ _007_ _113_ VGND VGND VPWR VPWR _035_ sky130_fd_sc_hd__o211a_1
XTAP_TAPCELL_ROW_5_43 VGND VPWR sky130_fd_sc_hd__tapvpwrvgnd_1
XPHY_EDGE_ROW_2_Right_2 VGND VGND VPWR VPWR sky130_fd_sc_hd__decap_3
XTAP_TAPCELL_ROW_12_53 VGND VPWR sky130_fd_sc_hd__tapvpwrvgnd_1
X_201_ _076_ _087_ _094_ _096_ VGND VGND VPWR VPWR net23 sky130_fd_sc_hd__o22a_1
XFILLER_10_102 VGND VGND VPWR VPWR sky130_fd_sc_hd__fill_1
XFILLER_5_3 VGND VGND VPWR VPWR sky130_fd_sc_hd__fill_1
X_132_ _061_ _028_ _029_ _033_ VGND VGND VPWR VPWR _034_ sky130_fd_sc_hd__o31ai_1
XFILLER_0_34 VGND VGND VPWR VPWR sky130_fd_sc_hd__decap_4
.ends
